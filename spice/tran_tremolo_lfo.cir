Tremolo Wien-bridge LFO -- ngspice transient (oscillator + frequency measure)
* TL072 half as a Wien-bridge oscillator with back-to-back diode amplitude
* limiting (D_lfo1/2). SCHEMATIC VALUES (tremolo sheet, errata #19): symmetric
* arms of R_lfo_ser / R_lfo_sh 15k + one gang each of the dual 250k speed pot,
* C_lfo1 / C_lfo2 1 uF. This is the fast end (pot = 0): f = 1/(2*pi*15k*1u) =
* 10.6 Hz; the slow end (pot 250k) is 0.60 Hz -- see sweep_lfo_speed.cir.

.include models/opamp1p.sub
.model DLIM D(Is=2.5n Rs=0.5 N=1.7 Cjo=4p Bv=100)   ; ~1N4148

* TL072 half
X1 P N OUT OPAMP1P PARAMS: aol=2e5 gbw=3e6

* Wien positive-feedback network (series RC + shunt RC)
R_ser OUT n1 15k
C_ser n1 P 1u
R_sh  P 0 15k
C_sh  P 0 1u

* negative feedback, gain = 1 + R_f/R_g = 1 + 10k/4.7k = 3.13 (>3 -> starts)
R_g N 0 4.7k
R_f OUT N 10k
* amplitude-limiting back-to-back diodes across R_f
Dl1 OUT N DLIM
Dl2 N OUT DLIM

.ic v(P)=0.05
.tran 0.5m 3 1 0.5m uic

.control
run
* measure one period from two successive rising zero-crossings (after settling)
meas tran t1 WHEN v(out)=0 RISE=3
meas tran t2 WHEN v(out)=0 RISE=4
let period = t2 - t1
let freq = 1/period
meas tran vamp MAX v(out)
print t1 t2 period freq vamp
.endc
.end
