PREAMP HEADROOM: both JFET stages, real guitar levels, with and without the source bypass caps
* The bias / gain checks (dc_preamp_jfet, sweep_preamp_bias) look at one stage with a
* small signal. This one drives the WHOLE preamp (Q1 -> C_cpl12 -> Q2, as on the Preamp
* sheet, RF stopper included) with a 1 kHz sine at pickup levels and reports the gain
* and the THD at the preamp output for three build options:
*   opt 0  C_s1 and C_s2 fitted (as drawn): ~22 dB per stage, 45 dB in front of the volume
*          control -- Q2's gate is overdriven by any normal pickup
*   opt 1  C_s2 omitted (Q2 degenerated by R_s2): Q2 gain ~4x, its input range ~6x larger
*   opt 2  C_s1 and C_s2 omitted: ~23 dB total, clean to several hundred mV
* Nothing changes on the board: the two bypass caps are through-hole electrolytics that
* are fitted by hand, so this is a population choice (see kicad/PCB-NOTES.md, bring-up).

.include models/jfet_2n5457.lib
.param opt=0
.param vin=0.1
V_dd VDD 0 17
V_in GUITAR_IN 0 SIN(0 {vin} 1000)
C_in_pre GUITAR_IN RF1 100n
R_rf1 RF1 Q1G 1k
C_rf1 Q1G 0 100p
R_g1 Q1G 0 1meg
J1 Q1D Q1G Q1S 2N5457
R_d1 VDD Q1D 10k
R_s1 Q1S 0 2.2k
C_s1 Q1S 0 {opt<2 ? 10u : 1p}
C_cpl12 Q1D Q2G 100n
R_g2 Q2G 0 1meg
J2 Q2D Q2G Q2S 2N5457
R_d2 VDD Q2D 10k
C_pres Q2D 0 100p
R_s2 Q2S 0 2.2k
C_s2 Q2S 0 {opt<1 ? 10u : 1p}
C_cpl_out Q2D PREAMP_OUT 1u
R_inb PREAMP_OUT 0 1meg

.control
set numdgt=4
foreach o 0 1 2
  foreach v 0.02 0.05 0.1 0.2 0.5
    alterparam opt = $o
    alterparam vin = $v
    reset
    tran 5u 60m 40m 5u
    meas tran vpp PP v(PREAMP_OUT) from=40m to=60m
    let gain = 20*log10(vpp/(2*$v))
    set sg="$&gain"
    set sv="$&vpp"
    echo ROW opt=$o vin_pk=$v V | out=$sv Vpp | gain=$sg dB   (THD on the next line)
    fourier 1000 v(PREAMP_OUT)
    destroy all
  end
end
.endc
.end
