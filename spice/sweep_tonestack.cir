Tone stack SWEEP: treble-cut response vs the tone-pot position
* Same network as ac_tonestack.cir (10k source, C_cut 10n -> POT_TONE rheostat to
* GND, 100k load); the pot is stepped from full-bright (100k) to full-cut (1k).
* Reports gain re: 1 V in at 1 kHz / 3 kHz / 5 kHz / 10 kHz -- the shape of the
* cut over the whole travel, not just its two ends.

V_in  IN 0 AC 1
R_src IN TONE_OUT 10k
C_cut TONE_OUT TCW 10n
R_tone TCW 0 {rt}
R_load TONE_OUT 0 100k
.param rt=100k

.control
echo "pot(ohm)  g_1k(dB)  g_3k(dB)  g_5k(dB)  g_10k(dB)"
foreach rt 100k 50k 20k 10k 5k 2k 1k
  alterparam rt=$rt
  reset
  ac dec 50 20 20k
  meas ac g1  FIND vdb(TONE_OUT) AT=1000
  meas ac g3  FIND vdb(TONE_OUT) AT=3000
  meas ac g5  FIND vdb(TONE_OUT) AT=5000
  meas ac g10 FIND vdb(TONE_OUT) AT=10000
  echo $rt  $&g1  $&g3  $&g5  $&g10
end
.endc
.end
