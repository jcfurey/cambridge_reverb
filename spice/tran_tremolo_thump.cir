TREMOLO: what reaches the loudspeaker with NO audio -- LFO feed-through and switching thumps
* The other tremolo decks put an AC source on a 0 V audio path. The real one sits at mid-rail,
* and the things that go wrong are DC things (errata #37, #38):
*   - the output buffer IC2-B was biased from VBIAS_T, the reference the LFO itself hangs
*     on. R_lfo_fb2, the Wien shunt arm and the depth pot pull 0.7-1 V pp of LFO frequency
*     on that node (100k / 100k / 47 uF), and the buffer followed it;
*   - the footswitch shorts the LED driver's base: C_drv (100 uF) then dumps its 0.9 V
*     into the depth pot -- with the depth at minimum straight into VBIAS_T;
*   - C_dc_blk (10 uF electrolytic, 8.5 V across it) leaks into TREM_S, which only the
*     vactrol's LDR ties to ground. Dark, the LDR is 50 M: TREM_S creeps up (time constant
*     500 s) and the next time the LED lights the charge goes into the audio.
* cfg 0 = as drawn, cfg 1 = as built: buffer on VBIAS_R; C_dc_blk 2.2 uF ceramic with a
* 220 k bleeder R_tb (the ceramic taken at its worst-case insulation resistance).
* Whole chain to the speaker: MRB coupling, buffer, LM1875 stage (ideal, gain 23, C_gain,
* input filter), C_out, 8 ohm.
.include models/opamp_rail.sub
.param cfg=1
.param mode=0
.param p=1
* cfg 0 = as drawn until errata #37 / #38; cfg 1 = as built
.param obufref = {cfg}
.param cdc     = {cfg==0 ? 10e-6 : 2.2e-6}
* leakage of C_dc_blk as a resistance at 8.5 V: a typical 10 uF electrolytic (0.1 uA),
* and the WORST the data sheet allows a 2.2 uF X7R (500 Mohm.uF)
.param rleak   = {cfg==0 ? 85e6 : 227e6}
.param rbleed  = {cfg==0 ? 1e12 : 220e3}
.param rmrbb   = {cfg==0 ? 1e12 : 1e6}
* mode 0: tremolo running, footswitch closes at 4 s and opens at 8 s
* mode 1: LED dark for minutes (footswitch closed since t = 0, TREM_S at its DC end
*         value), footswitch opens at 3 s
.param vts = {mode==0 ? 0 : 8.5*(1/(1/50e6 + 1/rbleed))/(rleak + 1/(1/50e6 + 1/rbleed))}
.param pot_speed = 40k
Vcc VCC 0 17
R_vbt1 VCC VBT 100k
R_vbt2 VBT 0 100k
C_vbt VBT 0 47u
R_vbr1 VCC VBR 100k
R_vbr2 VBR 0 100k
C_vbr VBR 0 47u
X_LFO LFO_P LFO_N LFO_OUT VCC 0 OPAMP_RAIL
R_lfo_ser LFO_OUT SPD_A 15k
R_spdA SPD_A WN1 {pot_speed}
C_lfo1 WN1 LFO_P 1u
R_lfo_sh LFO_P SPD_B 15k
R_spdB SPD_B VBT {pot_speed}
C_lfo2 LFO_P VBT 1u
R_lfo_fb1 LFO_OUT LFO_N 10k
R_lfo_fb2 LFO_N VBT 4.7k
D_lim1 LFO_OUT LFO_N DLED
D_lim2 LFO_N LFO_OUT DLED
I_kick 0 LFO_P PULSE(0 20u 0 1m 1m 5m 100)
.model DLED D(Is=1e-18 N=1.7 Rs=3)
R_dptA LFO_OUT DPT_W {(1-p)*100e3 + 1}
R_dptB DPT_W VBT {p*100e3 + 1}
C_drv DPT_W QDRV 100u
R_qb QDRV QB 1k
R_b1 VCC QB 180k
R_b2 QB 0 10k
* footswitch: closes at 4 s, opens at 8 s
V_fs FSC 0 PULSE({mode==0 ? 0 : 1} {mode==0 ? 1 : 0} {mode==0 ? 4 : 3} 1m 1m {mode==0 ? 4 : 100} 200)
S_fs QB 0 FSC 0 SWFS
.model SWFS SW(Vt=0.5 Vh=0.1 Ron=1 Roff=1e12)
Q_drv QC QB QE Q2N3904
R_e QE 0 470
R_c VCC VLR 100
D_v1 VLR SENS1 DLED
V_s1 SENS1 QC 0
.model Q2N3904 NPN(Is=6.7f Bf=200 Vaf=74 Ikf=0.08 Rb=10 Rc=1 Cje=4.5p Cjc=3.5p Tf=400p)
B_i ILED 0 V = { I(V_s1) }
R_lag ILED LIGHT 1k
C_lag LIGHT 0 5u
B_r RLDR 0 V = { min(50e6, (V(LIGHT) < 10e-3) ? 20e3*pow(max(V(LIGHT),1e-6)/1e-3,-1.52) : 600*pow(V(LIGHT)/10e-3,-0.79)) }
* ---- audio path at its real DC level: summer output BLEND sits at VBIAS_R
E_bl BLEND 0 VBR 0 1
R_trem1 BLEND TREM_OUT 10k
C_dc_blk TREM_OUT TREM_S {cdc}
R_cleak TREM_OUT TREM_S {rleak}
R_ldr TREM_S 0 R = { V(RLDR) }
R_tb TREM_S 0 {rbleed}
R_mrb_b MRB_OUT 0 {rmrbb}
C_mrb_in TREM_OUT MRB_N 100n
R_mrb_ser MRB_N MRB_T 10k
R_fs_mrb MRB_T 0 1Meg
C_mrb_out MRB_T MRB_OUT 100n
C_obuf_in MRB_OUT OBUF_IN 1u
R_ob1 OBUF_IN VBT {obufref==0 ? 100e3 : 1e15}
R_ob2 OBUF_IN VBR {obufref==1 ? 100e3 : 1e15}
X_OB OBUF_IN PA_IN PA_IN VCC 0 OPAMP_RAIL
C_in_pa PA_IN PA_LP 1u
R_lp PA_LP PA_BIAS 1k
C_lp PA_BIAS 0 22n
V_bref BREF 0 16.75
R_bias3 BREF PA_BIAS 22k
E_pa PA_OUT 0 PA_BIAS PA_INV 1e5
R_fb PA_OUT PA_INV 22k
R_gain PA_INV PA_GAIN 1k
C_gain PA_GAIN 0 22u
C_out PA_OUT SPK 2200u
R_spk SPK 0 8
.ic v(VBT)=8.5 v(VBR)=8.5 v(PA_GAIN)=16.75 v(PA_OUT)=16.75 v(TREM_S)={vts} v(TREM_OUT)=8.5 v(BLEND)=8.5
.control
foreach c 0 1
  foreach pp 1 0.5 0
    alterparam cfg = $c
    alterparam mode = 0
    alterparam p = $pp
    reset
    tran 200u 12 0 200u uic
    meas tran lfo_hi MAX v(SPK) from=2.5 to=4
    meas tran lfo_lo MIN v(SPK) from=2.5 to=4
    meas tran cl_hi MAX v(SPK) from=4 to=6
    meas tran cl_lo MIN v(SPK) from=4 to=6
    meas tran vbt_hi MAX v(VBT) from=2.5 to=4
    meas tran vbt_lo MIN v(VBT) from=2.5 to=4
    let run = lfo_hi - lfo_lo
    let close = cl_hi - cl_lo
    let vbtpp = vbt_hi - vbt_lo
    echo "cfg=$c running depth=$pp | LFO at the speaker=$&run Vpp | VBIAS_T moves $&vbtpp Vpp | footswitch closes: thump=$&close Vpp"
    destroy all
  end
  alterparam cfg = $c
  alterparam mode = 1
  alterparam p = 1
  reset
  tran 200u 6 0 200u uic
  meas tran op_hi MAX v(SPK) from=3 to=4.5
  meas tran op_lo MIN v(SPK) from=3 to=4.5
  meas tran ts0 FIND v(TREM_S) AT=2.9
  let open = op_hi - op_lo
  echo "cfg=$c engage after a long pause | TREM_S had floated to $&ts0 V | thump=$&open Vpp at the speaker"
  destroy all
end
.endc
.end
